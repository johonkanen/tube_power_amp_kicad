* pu_oneq_order_80_15_5_10ms (generated by run_sims.py)
.include /home/jari/dev/tube_power_amp_kicad/rev_c/sim/models/opa462_ti/OPA462.LIB
.include /home/jari/dev/tube_power_amp_kicad/rev_c/sim/opamp/opa462_ed.lib
.options rshunt=1e12
.model DS1G D(IS=5n N=1.8 RS=0.05 BV=400)
.model DGRID D(IS=1n N=2 RS=500)
V15src s15 0 PWL(0 0 0.1 0 0.11 15)
V80src s80 0 PWL(0 0 0.01 -80)
V5src s5 0 PWL(0 0 0.2 0 0.21 5)
B15reg s15 p15 I={max(0, V(s15,p15)) * 5}
R15bl p15 0 10k
B80reg m80in s80 I={max(0, V(m80in,s80)) * 5}
R80bl m80in 0 10k
R5src s5 p5 0.2
C302 p15 0 10u
C223 p15 0 100n
C303 p5 0 10u
R5load p5 0 1k
R201 m80in m80 10
D201 m80 0 DS1G
C201 m80 c201n 100u
RC201esr c201n 0 0.1
C202 m80 0 100n
C224 m80 0 100n
Bother p15 m80 I={3 * 3.45m * limit(V(p15,m80) / 5, 0, 1)}
Bextra 0 m80 I={1.2m * limit(-V(m80) / 10, 0, 1)}
R330 m80 mon 536k
R331 mon vref 10k
C331 mon 0 100n
Bref vri 0 V={1.0 * limit(V(p5) - 0.5, 0, 2.5) * limit((V(p5) - 1.2) / 0.3, 0, 1)}
Rref vri vref 1
C204 vref 0 1u
VDAC dac 0 DC 0
R210 dac in 10k
R211 in 0 115k
C210 in 0 330n
Vos in inp DC 0.0
Vsp p15 p15s 0
Vsm m80 m80s 0
XU210 inp fb p15s m80s oaout p5 0 OPA462ED
Vso oaout oa 0
R212 fb vref 10k
R213 oa fb 280k
C211 oa fb 1n
R214 oa bias 1k
C212 bias 0 1u
Vpi pis 0 DC 0
Rpi pis pi 40k
C110 pi g1 220n
R110 bias g1 91k
R112 g1 gk 5.6k
Cgk gk 0 15p
Dg gk 0 DGRID
.control
set noaskquit
set wr_singlescale
set wr_vecnames
option numdgt=9
tran 20u 0.81 0 50u uic
wrdata /home/jari/dev/tube_power_amp_kicad/rev_c/sim/opamp/work/pu_oneq_order_80_15_5_10ms.txt v(bias) v(oa) v(p15) v(m80) v(p5) v(vref) i(vso)
.endc
.end
