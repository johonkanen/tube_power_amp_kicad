* loop_derate_Co_0.25u (generated by run_sims.py)
.include /home/jari/dev/tube_power_amp_kicad/rev_c/sim/models/opa462_ti/OPA462.LIB
.include /home/jari/dev/tube_power_amp_kicad/rev_c/sim/opamp/opa462_ed.lib
.options rshunt=1e12
.model DS1G D(IS=5n N=1.8 RS=0.05 BV=400)
.model DGRID D(IS=1n N=2 RS=500)
V15src s15 0 DC 15
V80src s80 0 DC -80
V5src s5 0 DC 5
R15src s15 p15 0.2
R80src s80 m80in 0.2
R5src s5 p5 0.2
C302 p15 0 10u
C223 p15 0 100n
C303 p5 0 10u
R5load p5 0 1k
R201 m80in m80 10
D201 m80 0 DS1G
C201 m80 c201n 100u
RC201esr c201n 0 0.1
C202 m80 0 100n
C224 m80 0 100n
Bother p15 m80 I={3 * 3.45m * limit(V(p15,m80) / 5, 0, 1)}
Bextra 0 m80 I={1.2m * limit(-V(m80) / 10, 0, 1)}
R330 m80 mon 536k
R331 mon vref 10k
C331 mon 0 100n
Bref vri 0 V={1.0 * limit(V(p5) - 0.5, 0, 2.5) * limit((V(p5) - 1.2) / 0.3, 0, 1)}
Rref vri vref 1
C204 vref 0 1u
VDAC dac 0 DC 0.0
R210 dac in 10k
R211 in 0 115k
C210 in 0 330n
Vos in inp DC 0.0
Vsp p15 p15s 0
Vsm m80 m80s 0
XU210 inp fb p15s m80s oaout p5 0 OPA462ED
Vz oa oaout DC 0 AC 0
Iz 0 oaout DC 0 AC 0
R212 fb vref 10k
R213 oa fb 280k
C211 oa fb 1n
R214 oa bias 1k
C212 bias 0 0.25u
Vpi pis 0 DC 280
Rpi pis pi 40k
C110 pi g1 220n
R110 bias g1 91k
R112 g1 gk 5.6k
Cgk gk 0 15p
Dg gk 0 DGRID
.nodeset v(bias)=-69.9833
+ v(c201n)=0
+ v(dac)=0
+ v(fb)=0.000187191
+ v(g1)=-69.9833
+ v(gk)=-69.9833
+ v(in)=-1.76751e-06
+ v(inp)=-1.76751e-06
+ v(m80)=-79.8455
+ v(m80in)=-79.997
+ v(m80s)=-79.8455
+ v(mon)=0.991448
+ v(oa)=-69.9833
+ v(oaout)=-69.9833
+ v(p5)=4.999
+ v(p15)=14.9973
+ v(p15s)=14.9973
+ v(pi)=280
+ v(pis)=280
+ v(s5)=5
+ v(s15)=15
+ v(s80)=-80
+ v(vref)=2.4996
+ v(vri)=2.5
+ v(xu210.oi)=-69.9836
+ v(xu210.xu.cl_clamp)=-77.4783
+ v(xu210.xu.clamp)=-77.4733
+ v(xu210.xu.claw_clamp)=-77.4783
+ v(xu210.xu.esdn)=0.000187191
+ v(xu210.xu.esdp)=-1.76751e-06
+ v(xu210.xu.mid)=-32.4241
+ v(xu210.xu.n24207)=-1.76751e-06
+ v(xu210.xu.n24458)=-31.7817
+ v(xu210.xu.n24659)=-32.424
+ v(xu210.xu.n25397)=0.000140232
+ v(xu210.xu.n25415)=0.000150303
+ v(xu210.xu.n25921)=-48.0826
+ v(xu210.xu.n25929)=-32.4241
+ v(xu210.xu.n27785)=-12.6873
+ v(xu210.xu.n27793)=-32.424
+ v(xu210.xu.n28438)=0.000150303
+ v(xu210.xu.n28678)=0.000180924
+ v(xu210.xu.n31303)=0.000187191
+ v(xu210.xu.n31389)=11.9972
+ v(xu210.xu.n31737)=-78.8454
+ v(xu210.xu.n32236)=0.000180924
+ v(xu210.xu.n32347)=0.000180924
+ v(xu210.xu.n32510)=-32.4246
+ v(xu210.xu.n34005)=-83.9147
+ v(xu210.xu.n34013)=-77.4783
+ v(xu210.xu.n36262)=-77.4783
+ v(xu210.xu.n37029)=-695.639
+ v(xu210.xu.n37037)=-36.5997
+ v(xu210.xu.n45999)=-69.9836
+ v(xu210.xu.n46041)=-695.52
+ v(xu210.xu.n55560)=-32.4241
+ v(xu210.xu.n56849)=-32.4241
+ v(xu210.xu.n57321)=-32.4241
+ v(xu210.xu.n57325)=-32.4241
+ v(xu210.xu.n59739)=9.71595
+ v(xu210.xu.n59743)=-32.4241
+ v(xu210.xu.n59747)=-32.4241
+ v(xu210.xu.n59865)=-32.4241
+ v(xu210.xu.n59881)=-32.4241
+ v(xu210.xu.n59905)=-80.5741
+ v(xu210.xu.n65567)=617.576
+ v(xu210.xu.n65575)=-32.4241
+ v(xu210.xu.n65579)=-32.4241
+ v(xu210.xu.n65697)=-32.4241
+ v(xu210.xu.n65713)=-32.4241
+ v(xu210.xu.n65737)=-682.424
+ v(xu210.xu.n68774)=-77.4733
+ v(xu210.xu.n72064)=14.9465
+ v(xu210.xu.n72073)=-79.7955
+ v(xu210.xu.n72391)=-79.7955
+ v(xu210.xu.n72398)=14.9465
+ v(xu210.xu.n81574)=-32.4241
+ v(xu210.xu.n81664)=-32.4241
+ v(xu210.xu.n81756)=-32.4241
+ v(xu210.xu.n158495)=-77.4783
+ v(xu210.xu.n161737)=-32.674
+ v(xu210.xu.n161937)=-69.9836
+ v(xu210.xu.n1356061)=-80.9783
+ v(xu210.xu.n1356115)=-73.9783
+ v(xu210.xu.n1356333)=-80.9783
+ v(xu210.xu.n1356345)=-80.9783
+ v(xu210.xu.n1356409)=-73.9783
+ v(xu210.xu.n1356429)=-73.9783
+ v(xu210.xu.n2419074)=-77.4733
+ v(xu210.xu.n2425287)=-32.4241
+ v(xu210.xu.n2425309)=14.9972
+ v(xu210.xu.n2425325)=-79.8454
+ v(xu210.xu.sw_ol_opa462)=-32.4241
+ v(xu210.xu.v11)=-32.4241
+ v(xu210.xu.v12)=-32.4241
+ v(xu210.xu.vcc_b)=14.9972
+ v(xu210.xu.vcc_clp)=14.9465
+ v(xu210.xu.vclp)=-77.4783
+ v(xu210.xu.vee_b)=-79.8454
+ v(xu210.xu.vee_clp)=-79.7955
+ v(xu210.xu.vimon)=-32.674
+ v(xu210.xu.vout_s)=-69.9836
+ v(xu210.xu.vsense)=-77.4733
+ v(xu210.xu.x_u1.3)=0
+ v(xu210.xu.x_u1.4)=0
+ v(xu210.xu.x_u1.5)=0
+ v(xu210.xu.x_u1.6)=0
+ v(xu210.xu.x_u1.7)=0.833786
+ v(xu210.xu.x_u1.8)=0.833786
+ v(xu210.xu.x_u4.e1_int1)=0.000142
+ v(xu210.xu.x_u6.g1_int1)=32.4242
+ v(xu210.xu.x_u10.gvo+_int1)=0
+ v(xu210.xu.x_u10.gvo-_int1)=0
+ v(xu210.xu.x_u11.gvo+_int1)=0
+ v(xu210.xu.x_u11.gvo-_int1)=0
+ v(xu210.xu.x_u12.gvo+_int1)=0
+ v(xu210.xu.x_u12.gvo-_int1)=0
+ v(xu210.xu.x_u16.gsw+_int1)=0
+ v(xu210.xu.x_u18.g1_int1)=5.07197e-05
+ v(xu210.xu.x_u18.g1_int2)=-0.249942
+ v(xu210.xu.x_u19.g1_int1)=4.98807e-05
+ v(xu210.xu.x_u19.g1_int2)=0.249942
+ v(xu210.xu.x_u22.g1_int1)=0
+ v(xu210.xu.x_u23.g1_int1)=0
+ v(xu210.xu.x_u26.g1_int1)=0
+ v(xu210.xu.x_u27.g1_int1)=0.000249942
+ v(xu210.xu.x_u30.g1_int1)=-6.26743e-10
+ v(xu210.xu.x_u31.g1_int1)=-4.50494e-05
+ v(xu210.xu.x_u32.g1_int1)=-663.097
+ v(xu210.xu.x_u35.g1_int1)=0
+ v(xu210.xu.x_u36.3)=0
+ v(xu210.xu.x_u36.4)=0
+ v(xu210.xu.x_u36.5)=0
+ v(xu210.xu.x_u36.6)=0
+ v(xu210.xu.x_u36.7)=0.833786
+ v(xu210.xu.x_u36.8)=0.833786
+ v(xu210.xu.x_u37.3)=0
+ v(xu210.xu.x_u37.4)=0
+ v(xu210.xu.x_u37.5)=0
+ v(xu210.xu.x_u37.6)=0
+ v(xu210.xu.x_u37.7)=0.833786
+ v(xu210.xu.x_u37.8)=0.833786
.control
set noaskquit
op
let opcheck_dv = v(inp)-v(fb)
let opcheck_rail = v(m80)-v(s80)
print opcheck_dv opcheck_rail
set wr_singlescale
set wr_vecnames
option numdgt=9
alter @vz[acmag]=1
ac dec 50 1 100meg
alter @vz[acmag]=0
alter @iz[acmag]=1
ac dec 50 1 100meg
let V1 = ac1.v(oa)
let I1 = -ac1.i(vz)
let V2 = ac2.v(oa)
let I2 = -ac2.i(vz)
let X = I1*V2 - V1*I2
let Tp = 1/(2*X + V1 + I2) - 1
let Tm = 1/(-2*X + V1 + I2) - 1
let trp = real(Tp)
let tip = imag(Tp)
let trm = real(Tm)
let tim = imag(Tm)
wrdata /home/jari/dev/tube_power_amp_kicad/rev_c/sim/opamp/work/loop_derate_Co_0.25u.txt trp tip trm tim
.endc
.end
