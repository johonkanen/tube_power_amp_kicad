* loss_p5_dac1.25_dac_held (generated by run_sims.py)
.include /home/jari/dev/tube_power_amp_kicad/rev_c/sim/models/opa462_ti/OPA462.LIB
.include /home/jari/dev/tube_power_amp_kicad/rev_c/sim/opamp/opa462_ed.lib
.options rshunt=1e10
.model DS1G D(IS=5n N=1.8 RS=0.05 BV=400)
.model DGRID D(IS=1n N=2 RS=500)
V15src s15 0 DC 15
V80src s80 0 DC -80
V5src s5 0 PWL(0 5 50m 5 51m 0)
R15src s15 p15 0.2
R80src s80 m80in 0.2
R5src s5 p5 0.2
C302 p15 0 10u
C223 p15 0 100n
C303 p5 0 10u
R5load p5 0 1k
R201 m80in m80 10
D201 m80 0 DS1G
C201 m80 c201n 100u
RC201esr c201n 0 0.1
C202 m80 0 100n
C224 m80 0 100n
Bother p15 m80 I={3 * 3.45m * limit(V(p15,m80) / 5, 0, 1)}
Bextra 0 m80 I={1.2m * limit(-V(m80) / 10, 0, 1)}
R330 m80 mon 536k
R331 mon vref 10k
C331 mon 0 100n
Bref vri 0 V={1.0 * limit(V(p5) - 0.5, 0, 2.5) * limit((V(p5) - 1.2) / 0.3, 0, 1)}
Rref vri vref 1
C204 vref 0 1u
VDAC dac 0 DC 1.25
R210 dac in 10k
R211 in 0 115k
C210 in 0 330n
Vos in inp DC 0.0
Vsp p15 p15s 0
Vsm m80 m80s 0
XU210 inp fb p15s m80s oaout p5 0 OPA462ED
Vso oaout oa 0
R212 fb vref 10k
R213 oa fb 280k
C211 oa fb 1n
R214 oa bias 1k
C212 bias 0 1u
Vpi pis 0 DC 280
Rpi pis pi 40k
C110 pi g1 220n
R110 bias g1 91k
R112 g1 gk 5.6k
Cgk gk 0 15p
Dg gk 0 DGRID
.nodeset v(oa)=-36.6500 v(bias)=-36.6500 v(g1)=-36.6500 v(fb)=1.1500 v(inp)=1.1500 v(in)=1.1500 v(xu210.xu.clamp)=0 v(xu210.xu.vclp)=0 v(xu210.xu.vsense)=0
.control
set noaskquit
op
let opcheck_dv = v(inp)-v(fb)
let opcheck_rail = v(m80)-v(s80)
print opcheck_dv opcheck_rail
set wr_singlescale
set wr_vecnames
option numdgt=9
tran 50u 1.5 0 200u
wrdata /home/jari/dev/tube_power_amp_kicad/rev_c/sim/opamp/work/loss_p5_dac1.25_dac_held.txt v(bias) v(oa) v(m80) v(p15)
.endc
.end
